* SKY130 5-Stage Complementary Current-Starved Ring Oscillator
* Both NMOS and PMOS starving for wider tuning range
* Cross-coupled capacitive loading for noise reduction

.lib "sky130_models/sky130.lib.spice" tt

* Supply
Vdd vdd 0 1.8
Vss vss 0 0

* Control voltage
Vctrl vctrl 0 0.9

* Bias mirror: generate complementary PMOS control from Vctrl
* NMOS diode-connected driven by Vctrl creates Ibias, mirrored to PMOS side
XMbias_n nbias vctrl vss vss sky130_fd_pr__nfet_01v8 W={Wbn}u L={Lbn}u nf=1
Rbias nbias vdd {Rb}k
XMbias_p pbias nbias vdd vdd sky130_fd_pr__pfet_01v8 W={Wbp}u L={Lbp}u nf=1
XMbias_pd pbias pbias vdd vdd sky130_fd_pr__pfet_01v8 W={Wbp}u L={Lbp}u nf=1

* === Stage 1 ===
XMsp1 sp1 pbias vdd vdd sky130_fd_pr__pfet_01v8 W={Wsp}u L={Lsp}u nf=1
XMp1 n1 n5 sp1 vdd sky130_fd_pr__pfet_01v8 W={Wp}u L={Lp}u nf=1
XMn1 n1 n5 sn1 vss sky130_fd_pr__nfet_01v8 W={Wn}u L={Ln}u nf=1
XMsn1 sn1 vctrl vss vss sky130_fd_pr__nfet_01v8 W={Ws}u L={Ls}u nf=1
Cc1 n1 n3 {Cc}p

* === Stage 2 ===
XMsp2 sp2 pbias vdd vdd sky130_fd_pr__pfet_01v8 W={Wsp}u L={Lsp}u nf=1
XMp2 n2 n1 sp2 vdd sky130_fd_pr__pfet_01v8 W={Wp}u L={Lp}u nf=1
XMn2 n2 n1 sn2 vss sky130_fd_pr__nfet_01v8 W={Wn}u L={Ln}u nf=1
XMsn2 sn2 vctrl vss vss sky130_fd_pr__nfet_01v8 W={Ws}u L={Ls}u nf=1
Cc2 n2 n4 {Cc}p

* === Stage 3 ===
XMsp3 sp3 pbias vdd vdd sky130_fd_pr__pfet_01v8 W={Wsp}u L={Lsp}u nf=1
XMp3 n3 n2 sp3 vdd sky130_fd_pr__pfet_01v8 W={Wp}u L={Lp}u nf=1
XMn3 n3 n2 sn3 vss sky130_fd_pr__nfet_01v8 W={Wn}u L={Ln}u nf=1
XMsn3 sn3 vctrl vss vss sky130_fd_pr__nfet_01v8 W={Ws}u L={Ls}u nf=1
Cc3 n3 n5 {Cc}p

* === Stage 4 ===
XMsp4 sp4 pbias vdd vdd sky130_fd_pr__pfet_01v8 W={Wsp}u L={Lsp}u nf=1
XMp4 n4 n3 sp4 vdd sky130_fd_pr__pfet_01v8 W={Wp}u L={Lp}u nf=1
XMn4 n4 n3 sn4 vss sky130_fd_pr__nfet_01v8 W={Wn}u L={Ln}u nf=1
XMsn4 sn4 vctrl vss vss sky130_fd_pr__nfet_01v8 W={Ws}u L={Ls}u nf=1
Cc4 n4 n1 {Cc}p

* === Stage 5 ===
XMsp5 sp5 pbias vdd vdd sky130_fd_pr__pfet_01v8 W={Wsp}u L={Lsp}u nf=1
XMp5 n5 n4 sp5 vdd sky130_fd_pr__pfet_01v8 W={Wp}u L={Lp}u nf=1
XMn5 n5 n4 sn5 vss sky130_fd_pr__nfet_01v8 W={Wn}u L={Ln}u nf=1
XMsn5 sn5 vctrl vss vss sky130_fd_pr__nfet_01v8 W={Ws}u L={Ls}u nf=1
Cc5 n5 n2 {Cc}p

* Output buffer (fixed)
XMpout out n5 vdd vdd sky130_fd_pr__pfet_01v8 W=5u L=0.15u nf=1
XMnout out n5 vss vss sky130_fd_pr__nfet_01v8 W=2.5u L=0.15u nf=1

* Startup kick
Vkick kick 0 pulse(0 1.8 0 0.1n 0.1n 0.5n 1000n)
Ckick n1 kick 5f

.ic v(n1)=0 v(n2)=1.8 v(n3)=0 v(n4)=1.8 v(n5)=0

.options reltol=0.02 method=gear maxord=3

.control
tran 0.05n 200n uic

* Measure frequency using zero-crossings (cross counts both rising and falling)
meas tran tcross_a when v(n5)=0.9 cross=20
meas tran tcross_b when v(n5)=0.9 cross=30
let period = (tcross_b - tcross_a) / 5
let freq = 1 / period
echo "RESULT_FREQ_HZ" $&freq

* Power measurement
meas tran avg_idd avg i(Vdd) from=50n to=200n
let pwr = abs(avg_idd) * 1.8 * 1e6
echo "RESULT_POWER_UW" $&pwr

echo "RESULT_DONE"
.endc

.end
