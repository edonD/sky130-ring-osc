* SKY130 Complementary Current-Starved Ring Oscillator — 3-stage
* NMOS starving: direct Vctrl. PMOS starving: current mirror.
* VDD ramp startup with cap imbalance breaks symmetry for oscillation.

.lib "sky130_models/sky130_minimal.lib.spice" tt

* Supply — ramp from 0 to 1.8V to enable oscillation startup with uic
Vdd vdd 0 PWL(0 0 1n 1.8)
Vss vss 0 0

* Control voltage
Vctrl vctrl 0 0.9

* === Current mirror bias ===
XMref_n pbias vctrl vss vss sky130_fd_pr__nfet_01v8 W={Wbn}u L={Lbn}u nf=1
XMref_p pbias pbias vdd vdd sky130_fd_pr__pfet_01v8 W={Wbp}u L={Lbp}u nf=1

* === Stage 1 ===
XMp1 n1 n3 sp1 vdd sky130_fd_pr__pfet_01v8 W={Wp}u L={Lp}u nf=1
XMn1 n1 n3 sn1 vss sky130_fd_pr__nfet_01v8 W={Wn}u L={Ln}u nf=1
XMsp1 sp1 pbias vdd vdd sky130_fd_pr__pfet_01v8 W={Wsp}u L={Lsp}u nf=1
XMsn1 sn1 vctrl vss vss sky130_fd_pr__nfet_01v8 W={Wsn}u L={Lsn}u nf=1

* === Stage 2 ===
XMp2 n2 n1 sp2 vdd sky130_fd_pr__pfet_01v8 W={Wp}u L={Lp}u nf=1
XMn2 n2 n1 sn2 vss sky130_fd_pr__nfet_01v8 W={Wn}u L={Ln}u nf=1
XMsp2 sp2 pbias vdd vdd sky130_fd_pr__pfet_01v8 W={Wsp}u L={Lsp}u nf=1
XMsn2 sn2 vctrl vss vss sky130_fd_pr__nfet_01v8 W={Wsn}u L={Lsn}u nf=1

* === Stage 3 ===
XMp3 n3 n2 sp3 vdd sky130_fd_pr__pfet_01v8 W={Wp}u L={Lp}u nf=1
XMn3 n3 n2 sn3 vss sky130_fd_pr__nfet_01v8 W={Wn}u L={Ln}u nf=1
XMsp3 sp3 pbias vdd vdd sky130_fd_pr__pfet_01v8 W={Wsp}u L={Lsp}u nf=1
XMsn3 sn3 vctrl vss vss sky130_fd_pr__nfet_01v8 W={Wsn}u L={Lsn}u nf=1

* Output buffer (fixed)
XMpout out n3 vdd vdd sky130_fd_pr__pfet_01v8 W=5u L=0.15u nf=1
XMnout out n3 vss vss sky130_fd_pr__nfet_01v8 W=2.5u L=0.15u nf=1

* Capacitive imbalance on n1 for symmetry breaking during VDD ramp
Ckick n1 vss 50f

.options reltol=0.01 method=gear maxord=3

* === Measurements ===
.control
tran 0.1n 30n uic

* Measure frequency from output
meas tran trise1 when v(out)=0.9 rise=3
meas tran trise2 when v(out)=0.9 rise=4
let period = trise2 - trise1
let freq = 1 / period
echo "RESULT_FREQ_HZ" $&freq

* Power measurement
meas tran avg_idd avg i(Vdd) from=5n to=30n
let pwr = abs(avg_idd) * 1.8 * 1e6
echo "RESULT_POWER_UW" $&pwr

echo "RESULT_DONE"
.endc

.end
