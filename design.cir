* SKY130 Current-Starved Ring Oscillator — 3-stage, NMOS starving
* Simple topology: direct Vctrl on NMOS starving gates
* Optimized for speed, power, tuning range, and temperature stability

.lib "sky130_models/sky130_minimal.lib.spice" tt

* Supply
Vdd vdd 0 1.8
Vss vss 0 0

* Control voltage
Vctrl vctrl 0 0.9

* === Stage 1 ===
XMp1 n1 n3 vdd vdd sky130_fd_pr__pfet_01v8 W={Wp}u L={Lp}u nf=1
XMn1 n1 n3 ns1 vss sky130_fd_pr__nfet_01v8 W={Wn}u L={Ln}u nf=1
XMs1 ns1 vctrl vss vss sky130_fd_pr__nfet_01v8 W={Ws}u L={Ls}u nf=1

* === Stage 2 ===
XMp2 n2 n1 vdd vdd sky130_fd_pr__pfet_01v8 W={Wp}u L={Lp}u nf=1
XMn2 n2 n1 ns2 vss sky130_fd_pr__nfet_01v8 W={Wn}u L={Ln}u nf=1
XMs2 ns2 vctrl vss vss sky130_fd_pr__nfet_01v8 W={Ws}u L={Ls}u nf=1

* === Stage 3 ===
XMp3 n3 n2 vdd vdd sky130_fd_pr__pfet_01v8 W={Wp}u L={Lp}u nf=1
XMn3 n3 n2 ns3 vss sky130_fd_pr__nfet_01v8 W={Wn}u L={Ln}u nf=1
XMs3 ns3 vctrl vss vss sky130_fd_pr__nfet_01v8 W={Ws}u L={Ls}u nf=1

* Output buffer (fixed)
XMpout out n3 vdd vdd sky130_fd_pr__pfet_01v8 W=5u L=0.15u nf=1
XMnout out n3 vss vss sky130_fd_pr__nfet_01v8 W=2.5u L=0.15u nf=1

* Startup kick
Vkick kick 0 pulse(0 1.8 0 0.1n 0.1n 0.5n 1000n)
Ckick n1 kick 5f

.ic v(n1)=0 v(n2)=1.8 v(n3)=0

.options reltol=0.05 method=gear maxord=3

.control
tran 0.1n 100n uic
meas tran trise1 when v(n3)=0.9 rise=3
meas tran trise2 when v(n3)=0.9 rise=4
let period = trise2 - trise1
let freq = 1 / period
echo "RESULT_FREQ_HZ" $&freq
meas tran avg_idd avg i(Vdd) from=20n to=100n
let pwr = abs(avg_idd) * 1.8 * 1e6
echo "RESULT_POWER_UW" $&pwr
echo "RESULT_DONE"
.endc

.end
