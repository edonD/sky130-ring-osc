* SKY130 Current-Starved Ring Oscillator — 3-stage, NMOS starving, direct Vctrl
* Simplified topology: no current mirror, no varactors
* Vctrl directly drives NMOS starving transistors for wide tuning range

.lib "sky130_models/sky130.lib.spice" tt

* Supply
Vdd vdd 0 1.8
Vss vss 0 0

* Control voltage (sets oscillation frequency)
Vctrl vctrl 0 0.9

* === Stage 1 ===
XMp1 n1 n3 vdd vdd sky130_fd_pr__pfet_01v8 W={Wp}u L={Lp}u nf=1
XMn1 n1 n3 ns1 vss sky130_fd_pr__nfet_01v8 W={Wn}u L={Ln}u nf=1
XMs1 ns1 vctrl vss vss sky130_fd_pr__nfet_01v8 W={Ws}u L={Ls}u nf=1

* === Stage 2 ===
XMp2 n2 n1 vdd vdd sky130_fd_pr__pfet_01v8 W={Wp}u L={Lp}u nf=1
XMn2 n2 n1 ns2 vss sky130_fd_pr__nfet_01v8 W={Wn}u L={Ln}u nf=1
XMs2 ns2 vctrl vss vss sky130_fd_pr__nfet_01v8 W={Ws}u L={Ls}u nf=1

* === Stage 3 (output) ===
XMp3 n3 n2 vdd vdd sky130_fd_pr__pfet_01v8 W={Wp}u L={Lp}u nf=1
XMn3 n3 n2 ns3 vss sky130_fd_pr__nfet_01v8 W={Wn}u L={Ln}u nf=1
XMs3 ns3 vctrl vss vss sky130_fd_pr__nfet_01v8 W={Ws}u L={Ls}u nf=1

* Output buffer
XMpout out n3 vdd vdd sky130_fd_pr__pfet_01v8 W=5u L=0.15u nf=1
XMnout out n3 vss vss sky130_fd_pr__nfet_01v8 W=2.5u L=0.15u nf=1

* Kick start (small cap imbalance)
Ckick n1 vss 1f

.options reltol=0.01 method=gear maxord=3

* === Measurements ===
* evaluate.py sweeps Vctrl and computes tuning range externally
.control
tran 0.5n 200n

* Measure frequency from steady-state cycles
meas tran trise1 when v(out)=0.9 rise=5
meas tran trise2 when v(out)=0.9 rise=6
let period = trise2 - trise1
let freq = 1 / period
echo "RESULT_FREQ_HZ" $&freq

* Power measurement
meas tran avg_idd avg i(Vdd) from=50n to=200n
let pwr = abs(avg_idd) * 1.8 * 1e6
echo "RESULT_POWER_UW" $&pwr

echo "RESULT_DONE"
.endc

.end
